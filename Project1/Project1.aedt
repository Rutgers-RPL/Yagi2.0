# Ansys Electronics Desktop project, version 2023.2
materials:
  vacuum: permittivity=1
  aluminum: permeability=1.000021 conductivity=38000000

design HFSSDesign1 (HFSS, HFSS Terminal Network, model units mm)
geometry:
  Dipole_Antenna1 = component(Dipole_Antenna, 3D_Component_File_Path=<syslib>/3DComponents/HFSS/Antennas/Dipole/Dipole_Antenna_DM.a3dcomp, dipole_length=15.8cm, wire_rad=0.094cm, port_gap=0.094cm)
  arm1, arm1_1 [pec] = part_of(Dipole_Antenna1)
  port1 [vacuum] = part_of(Dipole_Antenna1)
  Cylinder1 [aluminum] = cylinder(axis=Z, base_centre=(0mm, 0mm, -79mm), radius=2mm, height=158mm)
  Dipole_Antenna1.move(TranslateVectorX=0mm TranslateVectorY=79mm TranslateVectorZ=0mm)
boundaries and excitations:
  Dipole_Antenna1_p1: Lumped Port Objects=port1 LumpedPortType=Modal Modes{Mode1{IntLine{(0, 79, -0.47) -> (0, 79, 0.47)} CharImp=Zpi RenormImp=50ohm}} Impedance=50ohm
source amplitudes:
  Dipole_Antenna1_p1:1: 1V 0deg
